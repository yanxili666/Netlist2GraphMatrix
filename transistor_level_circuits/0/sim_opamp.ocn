simulator( 'spectre )
design(	 "./netlist/netlist")
resultsDir( "./sim_results" )
modelFile(
    '("/apps/share/gm_id_mapping/tsmc18rf/1p6m/models/spectre/rf018.scs" "tt")
    '("/apps/share/gm_id_mapping/tsmc18rf/1p6m/models/spectre/rf018.scs" "tt_3v")
    '("/apps/share/gm_id_mapping/tsmc18rf/1p6m/models/spectre/rf018.scs" "tt_na")
    '("/apps/share/gm_id_mapping/tsmc18rf/1p6m/models/spectre/rf018.scs" "tt_3vna")
    '("/apps/share/gm_id_mapping/tsmc18rf/1p6m/models/spectre/rf018.scs" "tt_m")
    '("/apps/share/gm_id_mapping/tsmc18rf/1p6m/models/spectre/rf018.scs" "tt_3m")
    '("/apps/share/gm_id_mapping/tsmc18rf/1p6m/models/spectre/rf018.scs" "tt_bip")
    '("/apps/share/gm_id_mapping/tsmc18rf/1p6m/models/spectre/rf018.scs" "tt_bip3")
    '("/apps/share/gm_id_mapping/tsmc18rf/1p6m/models/spectre/rf018.scs" "dio")
    '("/apps/share/gm_id_mapping/tsmc18rf/1p6m/models/spectre/rf018.scs" "dio3")
    '("/apps/share/gm_id_mapping/tsmc18rf/1p6m/models/spectre/rf018.scs" "dio_dnw")
    '("/apps/share/gm_id_mapping/tsmc18rf/1p6m/models/spectre/rf018.scs" "tt_res")
    '("/apps/share/gm_id_mapping/tsmc18rf/1p6m/models/spectre/rf018.scs" "tt_mim")
    '("/apps/share/gm_id_mapping/tsmc18rf/1p6m/models/spectre/rf018.scs" "tt_rfmos")
    '("/apps/share/gm_id_mapping/tsmc18rf/1p6m/models/spectre/rf018.scs" "tt_rfmos33")
    '("/apps/share/gm_id_mapping/tsmc18rf/1p6m/models/spectre/rf018.scs" "tt_rfmim")
    '("/apps/share/gm_id_mapping/tsmc18rf/1p6m/models/spectre/rf018.scs" "tt_rfind")
    '("/apps/share/gm_id_mapping/tsmc18rf/1p6m/models/spectre/rf018.scs" "tt_rfmvar")
    '("/apps/share/gm_id_mapping/tsmc18rf/1p6m/models/spectre/rf018.scs" "tt_rfjvar")
    '("/apps/share/gm_id_mapping/tsmc18rf/1p6m/models/spectre/rf018.scs" "tt_rfres_sa")
    '("/apps/share/gm_id_mapping/tsmc18rf/1p6m/models/spectre/rf018.scs" "tt_rfres_rpo")
    '("/apps/share/gm_id_mapping/tsmc18rf/1p6m/models/spectre/rf018.scs" "tt_rfres_hri")
    '("/apps/share/gm_id_mapping/tsmc18rf/1p6m/models/spectre/rf018.scs" "tt_rfesd")
    '("/apps/share/gm_id_mapping/tsmc18rf/1p6m/models/spectre/rf018.scs" "tt_bbmvar")
)
analysis('dc ?saveOppoint t  )
analysis('ac ?start "1"  ?stop "0.1G"  ?dec "100"  )
envOption(	'analysisOrder  list("dc" "ac") )
option( ?categ 'turboOpts        'uniMode  "APS")
saveOption( 'save "all" )
temp( 27 )
run()
gain = value(db(vfreq('ac "net_vo")) 1)
pm = phaseMargin(VF("net_vo"))
gbw = cross(db(vfreq('ac "net_vo")) 0 1 "either" nil nil)
pw = abs(OP("V1" "pwr"))
ocnPrint(?output "./sim.out", ?precision 16 ?width 20 ?numberNotation 'scientific gain pm gbw pw)
exit
